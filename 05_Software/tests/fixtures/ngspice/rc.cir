RC low-pass (E04-A)
V1 in 0 DC 0 AC 1 PULSE(0 1 0 1n 1n 1 2)
R1 in out 1k
C1 out 0 1u
.end
