star-hash control line
V1 a 0 DC 1
R1 a 0 1k
*#echo STAR-HASH-RAN
.end
