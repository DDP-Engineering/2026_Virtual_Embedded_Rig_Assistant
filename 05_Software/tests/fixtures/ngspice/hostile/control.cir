hostile control block
V1 a 0 DC 1
R1 a 0 1k
.control
shell echo pwned
.endc
.end
