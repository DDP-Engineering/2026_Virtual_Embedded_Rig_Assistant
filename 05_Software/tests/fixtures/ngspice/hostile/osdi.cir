hostile osdi on a continuation
V1 a 0 DC 1
R1 a 0
+ 1k pre_osdi
.end
