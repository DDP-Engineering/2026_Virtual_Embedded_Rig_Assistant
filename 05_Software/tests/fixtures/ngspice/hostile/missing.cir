hostile missing include
.include nothere.lib
V1 a 0 DC 1
R1 a 0 1k
.end
