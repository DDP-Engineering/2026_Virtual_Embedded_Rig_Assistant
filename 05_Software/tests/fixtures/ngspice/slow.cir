Slow circuit for the time limit
V1 a 0 PULSE(0 1 0 1n 1n 5n 10n)
R1 a b 1
L1 b c 1n
C1 c 0 1n
R2 c 0 1k
.end
