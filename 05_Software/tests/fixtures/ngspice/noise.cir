Thermal noise of two 1k resistors (500 ohm at the output)
V1 in 0 DC 0 AC 1
R1 in out 1k
R2 out 0 1k
.end
