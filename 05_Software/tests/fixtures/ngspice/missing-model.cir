Missing model (E04-C)
V1 in 0 DC 5
D1 in 0 DNOPE
.end
