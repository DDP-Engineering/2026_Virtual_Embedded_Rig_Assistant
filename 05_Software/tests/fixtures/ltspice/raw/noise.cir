* resistor noise (raw fixture)
V1 in 0 0 AC 1
R1 in out 1k
R2 out 0 1k
.noise V(out) V1 dec 5 10 1k
.end
