* rc ac (raw fixture)
V1 in 0 AC 1
R1 in out 1k
C1 out 0 1u
.ac dec 5 10 10k
.end
