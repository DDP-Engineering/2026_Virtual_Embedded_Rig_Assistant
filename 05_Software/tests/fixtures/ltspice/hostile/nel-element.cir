Hostile netlist: refused before LTspice runs
V1 out 0 1
R1 out 0 1k
R2 out 0 1k ; c.wave C:\vera-nel.wav 16 44.1k V(out)
.end
