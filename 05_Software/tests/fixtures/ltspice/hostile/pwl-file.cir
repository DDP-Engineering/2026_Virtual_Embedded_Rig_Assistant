Hostile netlist: refused before LTspice runs
V1 out 0 1
R1 out 0 1k
V2 a 0 PWL file=secret.txt
R2 a 0 1k
.end
