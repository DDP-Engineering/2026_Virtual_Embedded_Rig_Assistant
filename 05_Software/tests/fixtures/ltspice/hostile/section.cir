Hostile netlist: refused before LTspice runs
V1 out 0 1
R1 out 0 1k
.lib "section.lib" TT
.end
