Hostile netlist: refused before LTspice runs
V1 out 0 1
R1 out 0 1k
V2 b 0 PWL file secret.txt
R2 b 0 1k
.end
