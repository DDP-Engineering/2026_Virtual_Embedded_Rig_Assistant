Hostile netlist: refused before LTspice runs
V1 out 0 1
R1 out 0 1k
@1 out 0 fra
.end
