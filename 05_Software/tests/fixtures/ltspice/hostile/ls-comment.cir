Hostile netlist: refused before LTspice runs
V1 out 0 1
R1 out 0 1k
* note .wave C:\vera-ls.wav 16 44.1k V(out)
.end
