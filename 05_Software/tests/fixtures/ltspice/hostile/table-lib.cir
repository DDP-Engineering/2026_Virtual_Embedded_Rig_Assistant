Hostile netlist: refused before LTspice runs
V1 out 0 1
R1 out 0 1k
B1 a 0 V=table(time, .lib "secret.txt")
R2 a 0 1k
.end
