Missing diode model (E05-D)
V1 a 0 5
R1 a b 1k
D1 b 0 DNOPE
.end
