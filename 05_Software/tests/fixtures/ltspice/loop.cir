Algebraic loop that cannot converge (E05-D)
V1 in 0 1
B1 out 0 V=if(V(out)>0.5,0,1)
R1 out 0 1k
.end
