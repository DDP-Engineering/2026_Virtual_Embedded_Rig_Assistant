Upper-case M is milli
V1 a 0 1
R1 a 0 1M
.op
.end
